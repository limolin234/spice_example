.include ./cir/main.par

.subckt main in out
R0 in out {RV}
.ends main
